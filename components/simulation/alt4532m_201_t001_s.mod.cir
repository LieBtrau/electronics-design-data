*----------------------------------------------------------------------
* SPICE Netlist Generated by TDK Corporation
* Copyright(C) 2015 TDK Corporation.
* All Rights Reserved.
*----------------------------------------------------------------------
* TDK P/N: ALT4532M-201-T001 (Pulse Transformer)
* Property: L=200uH min. [DC bias 8mA, 100kHz]
* Size(LxWxT): 4.5x3.2x2.9mm, 0.177x0.126x0.114inches
* Model Type: Simple Model
* Model Generated on June 29, 2015
*----------------------------------------------------------------------
* Terms and conditions regarding TDK Simulation Models:
* 1)This simulation model is being provided solely for informational
*   purposes. Please refer to the specifications of the products in
*   terms of detailed characteristics of such products.
* 2)In no event shall TDK Corporation of any of its subsidiaries be
*   liable for any loss or damage arising, directly or indirectly,
*   from any information contained in this simulation model, including,
*   but not limited to loss or damages arising from any inaccuracies,
*   omissions or errors in connection with such information.
* 3)Any and all copyrights on this simulation model are owned by
*   TDK Corporation.  Duplication or redistribution of this simulation
*   model without prior written permission from TDK Corporation
*   is prohibited.
* 4)This simulation model is subject to any modification or change
*   without any prior notice.
* 5)Neither TDK Corporation nor any of its subsidiaries shall make any
*   warranty, express or implied, including but not limited to the
*   correctness, implied warranties of merchantability and fitness for
*   a particular purpose with respect to this simulation models.
* 6)The use of this simulation model shall be deemed to have consented
*   to the terms and conditions hereof.
*----------------------------------------------------------------------
* External Node Assignments:
*
*  n1 ---) (--- n5
*        ) (
*  n6 ---) (--- n3
*        ) (
*  n2 ---) (--- n4
*
*----------------------------------------------------------------------
* Applicable Conditions:
*   Temperature = 25 degC
*   DC Bias Current = 0 A
*   Small Signal Operation
*----------------------------------------------------------------------
.SUBCKT ALT4532M_201_T001_s n1 n2 n3 n4 n5 n6
C111 12 51 1.00000000E-13
C112 22 61 1.00000000E-13
C113 32 51 1.00000000E-13
C114 42 61 1.00000000E-13
C151 12 22 4.90000000E-12
C152 32 42 4.90000000E-12
C153 12 32 4.90000000E-12
C154 22 42 4.90000000E-12
C155 12 42 4.90000000E-12
C156 22 32 4.90000000E-12
K112 L111 L112 9.99740000E-01
K113 L111 L113 9.99740000E-01
K114 L111 L114 9.99840000E-01
K123 L112 L113 9.99840000E-01
K124 L112 L114 9.99740000E-01
K134 L113 L114 9.99740000E-01
L111 12 51 9.10000000E-05
L112 22 61 9.10000000E-05
L113 51 32 9.10000000E-05
L114 61 42 9.10000000E-05
L121 11 12 1.15000000E-08
L122 21 22 1.15000000E-08
L123 31 32 1.15000000E-08
L124 41 42 1.15000000E-08
L131 n6 51 1.00000000E-08
L132 n3 61 1.00000000E-08
R111 12 51 5.90000000E+03
R112 22 61 5.90000000E+03
R113 32 51 5.90000000E+03
R114 42 61 5.90000000E+03
R121 11 12 1.40000000E+02
R122 21 22 1.40000000E+02
R123 31 32 1.40000000E+02
R124 41 42 1.40000000E+02
R131 n6 51 2.80000000E+02
R132 n3 61 2.80000000E+02
R141 n1 11 1.50000000E+00
R142 n5 21 1.50000000E+00
R143 n2 31 1.50000000E+00
R144 n4 41 1.50000000E+00
R151 12 22 1.00000000E+11
R152 32 42 1.00000000E+11
R153 12 32 1.00000000E+11
R154 22 42 1.00000000E+11
R155 12 42 1.00000000E+11
R156 22 32 1.00000000E+11
.ENDS ALT4532M_201_T001_s
*----------------------------------------------------------------------
